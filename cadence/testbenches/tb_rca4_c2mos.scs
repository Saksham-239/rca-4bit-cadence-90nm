// ==============================================================================
// Cadence Spectre Testbench: 4-Bit C²MOS (Clocked CMOS) Ripple Carry Adder
// Technology: gpdk090 (90nm Bulk CMOS, VDD = 1.0V)
// ==============================================================================

simulator lang=spectre
global 0

// Include PDK Model & Spectre Alias
include "/home/work/gpdk090/models/spectre/gpdk090.scs" section=stat
include "../model_alias.scs"

// Include Circuit Netlists
simulator lang=spice
.include "../rca_all_designs.sp"
simulator lang=spectre

// DUT: 4-Bit C²MOS RCA
// Order: a0 a1 a2 a3 b0 b1 b2 b3 cin clk clkb s0 s1 s2 s3 cout vdd gnd
XRCA (a0 a1 a2 a3 b0 b1 b2 b3 cin clk clkb s0 s1 s2 s3 cout vdd 0) RCA4_C2MOS

// Power Supply (VDD = 1.0 V)
Vdd (vdd 0) vsource dc=1.0 type=dc

// Anti-Phase Clocks (500 MHz, phi and phi_bar)
Vclk  (clk  0) vsource type=pulse val0=0.0 val1=1.0 period=2n delay=0 rise=20p fall=20p width=1n
Vclkb (clkb 0) vsource type=pulse val0=1.0 val1=0.0 period=2n delay=0 rise=20p fall=20p width=1n

// Operand Inputs: A = 1111 (1.0V DC), B = 0000 (0.0V DC)
Va0 (a0 0) vsource dc=1.0 type=dc
Va1 (a1 0) vsource dc=1.0 type=dc
Va2 (a2 0) vsource dc=1.0 type=dc
Va3 (a3 0) vsource dc=1.0 type=dc

Vb0 (b0 0) vsource dc=0.0 type=dc
Vb1 (b1 0) vsource dc=0.0 type=dc
Vb2 (b2 0) vsource dc=0.0 type=dc
Vb3 (b3 0) vsource dc=0.0 type=dc

// Carry-In Pulse Stimulus (Transitions at 10ns to align with evaluation phase)
Vcin (cin 0) vsource type=pulse val0=0.0 val1=1.0 period=20n delay=10n rise=20p fall=20p width=10n

// Output Load Capacitors (2 fF each)
CL0 (s0 0) capacitor c=2f
CL1 (s1 0) capacitor c=2f
CL2 (s2 0) capacitor c=2f
CL3 (s3 0) capacitor c=2f
CLC (cout 0) capacitor c=2f

// Simulation Options & Transient Analysis
simulatorOptions options reltol=1e-3 vabstol=1e-6 iabstol=1e-12 temp=27 tnom=27
tran tran stop=20n errpreset=moderate write="spectre.ic" writefinal="spectre.fc" annotate=status

// Save Outputs to Waveform File
save clk clkb cin s0 s1 s2 s3 cout
saveOptions options save=allpub
