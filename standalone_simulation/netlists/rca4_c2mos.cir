* 4-Bit RCA Benchmark - C2MOS CMOS 90nm
.include "/mnt/c/Users/saksh/.gemini/antigravity/scratch/rca_90nm_project/models/ptm_90nm.pm"
.param VDD_VAL = 1.0V
Vdd vdd 0 DC 'VDD_VAL'

* C²MOS 1-Bit Full Adder
* Anti-phase Clock-Gated Inverting Stages (Phi and Phi_bar)
.subckt FA_C2MOS a b cin clk clk_b sum cout vdd 0

* --- Stage 1: Carry Generation (Clocked on Phi) ---
* PUN (PMOS logic + PMOS clock gate driven by clk_b)
Mp_c1 n_cp1 a   vdd vdd pmos_90nm w=420n l=100n
Mp_c2 n_cp2 b   n_cp1 vdd pmos_90nm w=420n l=100n
Mp_c3 n_cp3 cin vdd vdd pmos_90nm w=420n l=100n
Mp_c4 n_cg  a   n_cp3 vdd pmos_90nm w=420n l=100n
Mp_c5 n_cg  b   n_cp3 vdd pmos_90nm w=420n l=100n
Mp_cclk cout_b clk_b n_cg vdd pmos_90nm w=420n l=100n

* PDN (NMOS clock gate driven by clk + NMOS logic)
Mn_cclk cout_b clk n_cn 0 nmos_90nm w=360n l=100n
Mn_c1 n_cn  a   n_cn1 0 nmos_90nm w=360n l=100n
Mn_c2 n_cn1 b   0     0 nmos_90nm w=360n l=100n
Mn_c3 n_cn  cin n_cn2 0 nmos_90nm w=360n l=100n
Mn_c4 n_cn2 a   0     0 nmos_90nm w=360n l=100n
Mn_c5 n_cn2 b   0     0 nmos_90nm w=360n l=100n

* Stage 2: Output Inverter for Cout
Mp_cinv cout cout_b vdd vdd pmos_90nm w=420n l=100n
Mn_cinv cout cout_b 0   0   nmos_90nm w=120n l=100n

* --- Sum Generation (C²MOS Stage) ---
Mp_s1 n_sp1 a    vdd vdd pmos_90nm w=420n l=100n
Mp_s2 n_sp1 b    vdd vdd pmos_90nm w=420n l=100n
Mp_s3 n_sp1 cin  vdd vdd pmos_90nm w=420n l=100n
Mp_sclk sum_b clk_b n_sp1 vdd pmos_90nm w=420n l=100n

Mn_sclk sum_b clk n_sn1 0 nmos_90nm w=360n l=100n
Mn_s1 n_sn1 a   0 0 nmos_90nm w=360n l=100n
Mn_s2 n_sn1 b   0 0 nmos_90nm w=360n l=100n
Mn_s3 n_sn1 cin 0 0 nmos_90nm w=360n l=100n

* Stage 2: Output Inverter for Sum
Mp_sinv sum sum_b vdd vdd pmos_90nm w=420n l=100n
Mn_sinv sum sum_b 0   0   nmos_90nm w=120n l=100n

.ends FA_C2MOS

* Operand Inputs: A=1111, B=0000
VA0 a0 0 DC 1.0
VA1 a1 0 DC 1.0
VA2 a2 0 DC 1.0
VA3 a3 0 DC 1.0

VB0 b0 0 DC 0.0
VB1 b1 0 DC 0.0
VB2 b2 0 DC 0.0
VB3 b3 0 DC 0.0

* Carry-In Step Input (Transition 0 -> 1 at 1.0ns)
Vcin c0 0 PULSE(0.0 1.0 1.0n 20p 20p 2.0n 5.0n)

* Clocks: Phi and Phi_bar
Vclk clk 0 PULSE(0.0 1.0 1.0n 20p 20p 1.0n 2.0n)
Vclk_b clk_b 0 PULSE(1.0 0.0 1.0n 20p 20p 1.0n 2.0n)

* 4-Bit RCA Chain (C²MOS)
XFA0 a0 b0 c0 clk clk_b s0 c1 vdd 0 FA_C2MOS
XFA1 a1 b1 c1 clk clk_b s1 c2 vdd 0 FA_C2MOS
XFA2 a2 b2 c2 clk clk_b s2 c3 vdd 0 FA_C2MOS
XFA3 a3 b3 c3 clk clk_b s3 c4 vdd 0 FA_C2MOS

CL0 s0 0 2f
CL1 s1 0 2f
CL2 s2 0 2f
CL3 s3 0 2f
CLC c4 0 2f

.control
tran 1p 3.0n

* Worst-Case Carry Propagation Delay: C0 (50%) -> C4 (50%)
meas tran tp_carry trig v(c0) val=0.5 rise=1 targ v(c4) val=0.5 rise=1
meas tran tp_c1 trig v(c0) val=0.5 rise=1 targ v(c1) val=0.5 rise=1
meas tran tp_c2 trig v(c0) val=0.5 rise=1 targ v(c2) val=0.5 rise=1
meas tran tp_c3 trig v(c0) val=0.5 rise=1 targ v(c3) val=0.5 rise=1

* Average Power Dissipation: Integral of Vdd * I(Vdd) / Period
meas tran avg_curr avg i(Vdd) from=1.0n to=2.0n
let avg_pwr = -avg_curr * 1.0
print avg_pwr tp_carry

* Export waveforms to raw table
wrdata /mnt/c/Users/saksh/.gemini/antigravity/scratch/rca_90nm_project/results/c2mos_waveforms.txt v(c0) v(c1) v(c2) v(c3) v(c4)
quit
.endc
.end
